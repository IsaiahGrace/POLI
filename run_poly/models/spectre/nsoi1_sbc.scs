subckt nsoi1_sbc (S G D B X)
parameters \
	l=0  \
	w=0  \
	nf=1  \

nsoi1_sbc (S G D B X) ps_nsoi1 l=l w=nf*w nf=nf

ends nsoi1_sbc
