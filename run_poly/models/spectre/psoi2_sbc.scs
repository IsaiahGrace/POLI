subckt psoi2_sbc (S G D B X)
parameters \
	l=0  \
	w=0  \
	nf=1  \

psoi2_sbc (S G D B X) ps_psoi2 l=l w=nf*w nf=nf

ends psoi2_sbc
