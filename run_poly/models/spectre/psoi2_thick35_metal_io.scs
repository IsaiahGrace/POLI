**  MITLL 90nm SOI     12_21_2011
**  alpha model for evaluation purposes only
model psoi2_thick35_metal_io bsimsoi type=p
+level    = 70             tnom     = 22             version  = 4.4
+tox      = 1.7e-09        tsi      = 3.2e-08        tbox     = 1.42e-07
+xj       = 1e-07          nch      = 4e+17          nsub     = -1e+15
+vth0     = -.710         k1       = 0.451          k2       = 0
+k3       = 0.476          k3b      = 0              k1w1     = 0
+k1w2     = 0              kb1      = 0              w0       = 0
+lpe0     = -1e-08         lpeb     = 0              dvt0w    = 0
+agidl    = 1.5e-12        bgidl    = 1e+09          egidl    = 0
+cgidl    = 0              agisl    = 5e-13          bgisl    = 1e+09
+egisl    = 0              dvt1w    = 100000         dvt2w    = 0
+dvt0     = 1.09           dvt1     = 0.214          dvt2     = 0
+u0       = 54             ua       = 0              ub       = 0
+uc       = 0              vsat     = 80000          a0       = 0.372
+ags      = 0              b0       = 0              b1       = 0
+fbjtii   = 0              esatii   = 1e+08          sii0     = 1
+sii1     = 0              sii2     = 0              siid     = 0
+keta     = 0              ketas    = 0              rth0     = 0.08
+a1       = 0              a2       = 0.99           rdsw     = 60
+prwg     = 0              prwb     = 0              wr       = 0.85
+wint     = 1.6e-08        lint     = -7.98e-9      dwg      = 0
+dwb      = 0              voff     = -0.2           nfactor  = 4.5
+cit      = 0              cdsc     = 0.002          cdscd    = -0.004
+cdscb    = 0              beta0    = 0              beta1    = 0
+beta2    = 0.13           eta0     = 0.0529         etab     = 0
+dsub     = 0.104          pclm     = 0.675          pdiblc1  = 0.18
+pdiblc2  = 0              pdiblcb  = 0              drout    = 0.571
+pvag     = 0              delta    = 0.01           ngate    = 1e+20
+alpha0   = 0              vdsatii0 = 1.14           mobmod   = 1
+tii      = -0.226         prt      = 10             ute      = -1.8
+kt1      = -0.16          kt1l     = 0              lii      = 0
+kt2      = -0.0646        ua1      = 0              ub1      = 0
+uc1      = 0              at       = 34000          tcjswg   = 0.0005
+wl       = 0              wln      = 1              ww       = 0
+wwn      = 1              wwl      = 0              ll       = 0
+lln      = 2              lw       = 0              lwn      = 1
+lwl      = 0              capmod   = 2              xpart    = 0
+cjswg    = 8e-10          pbswg    = 0.9            mjswg    = 0.5
+csdesw   = 0              csdmin   = 1.6e-05        cgdo     = 6e-10
+cgso     = 2.5e-10        cgeo     = 0              cgsl     = 0
+cgdl     = 0              ckappa   = 0.6            cf       = 0
+clc      = 5e-08          cle      = 0.6            binunit  = 1
+shmod    = 1              rbody    = 10             rbsh     = 100
+cth0     = 1e-05          ndiode   = 1.04           ntun     = 10
+vtun0    = 0              isbjt    = 3e-07          nbjt     = 1.5
+lbjt0    = 2e-07          vabjt    = 10             aely     = 0
+ahli     = 1e-15          isdif    = 4.5e-08        isrec    = 0.0001
+istun    = 1e-05          xbjt     = 1.15           xdif     = 1.11
+xrec     = 0.9            xtun     = 0              ntrecf   = -0.3
+ntrecr   = 10             tt       = 3e-10          ln       = 1e-09
+nrecf0   = 1.6            nrecr0   = 10             vrec0    = 0.05
+vsdth    = -0.3           vsdfb    = -0.8           asd      = 0.3
+dlcb     = 0              dlbg     = 0              delvt    = 0
+fbody    = 1              acde     = 0.11           moin     = 15
+ldif0    = 0.001          ndif     = -1             soimod   = 1
+fdmod    = 0              vbsa     = 0              dvbd1    = 0.3
+dvbd0    = 0              nofffd   = 1              vofffd   = 0
+moinfd   = 1e+06          dk2b     = 0.3            k2b      = 0.5
+wth0     = 4e-06          rhalo    = 1e+15          nrb      = 1
+k1b      = 1.1            rgatemod = 1              rshg     = 1.6
+xrcrg1   = 12             xrcrg2   = 1              ngcon    = 1
+xgw      = 0              xgl      = 0              wpclm    = 0.5
+lpclm    = 0              gidlmod  = 0              dvtp0    = 0
+dvtp1    = 0              dvtp2    = 0              dvtp3    = 0
+dvtp4    = 0              igcmod   = 1              igbmod   = 1
+toxref   = 1.7e-09        poxedge  = 1              aigc     = 0.009
+bigc     = 0              cigc     = 0.1            nigc     = 4
+aigs     = 0.01           bigs     = 0.0008         cigs     = 0.03
+aigd     = 0.01           bigd     = 0.0008         cigd     = 0.03
+toxqm    = 1.8e-09        ebg      = 1.2            alphagb1 = 0.35
+betagb1  = 0.03           vgb1     = 300            vevb     = 0.075
+alphagb2 = 0.43           betagb2  = 0.05           vgb2     = 17
+vecb     = 0.026          aigbcp2  = 0.043          bigbcp2  = 0.0054
+cigbcp2  = 0.0075
