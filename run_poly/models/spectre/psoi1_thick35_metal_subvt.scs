model psoi1_thick35_metal_subvt bsimsoi type=p
+level    = 70             tnom     = 22             version  = 4.4
+tox      = 3.5e-09          tsi      = 2.5e-08        tbox     = 1.4e-07
+xj       = 1e-07          nch      = 1e+15          nsub     = -2e+14
+vth0     = -0.4           k1       = 0.01           k2       = 0
+k3       = 20             k3b      = 0              k1w1     = 0
+k1w2     = 0              w0       = 5e-07          dvt0w    = 0
+dvt1w    = 1e+06          dvt2w    = 0              lpe0     = 0
+lpeb     = 0              dvt0     = 0.12           dvt1     = 0.2
+dvt2     = 0              dvtp0    = 0              dvtp1    = 1
+u0       = 130            ua       = 0              ub       = 1.6e-18
+uc       = 0              vsat     = 80000          a0       = -6
+ags      = 0              b0       = 0              b1       = 0
+agidl    = 2e-12          bgidl    = 9e+08          egidl    = 0
+cgidl    = 0              fbjtii   = 0              esatii   = 1e+08
+sii0     = 1.5            sii1     = 0              sii2     = 0
+siid     = 0              keta     = 0              ketas    = 0
+rth0     = 0.07           a1       = 0              a2       = 0.99
+rdsw     = 2300           prwg     = 0              prwb     = 0
+wr       = 1              wint     = 0              lint     = -1.38e-07
+dwg      = 0              dwb      = 0              voff     = -0.2
+nfactor  = 1              cit      = 0              cdsc     = 0.0012
+cdscd    = 0.0006         cdscb    = 0              minv     = -0.8
+beta0    = 0              beta1    = 0              beta2    = 0.25
+eta0     = 0.1            etab     = 0              dsub     = 0.6
+pclm     = 5              pdiblc1  = 0              pdiblc2  = 0
+pdiblcb  = 0              drout    = 0.4            pvag     = 0
+delta    = 0.01           ngate    = 1e+21          alpha0   = 4e-07
+vdsatii0 = 0.9            mobmod   = 1              tii      = -0.2264
+prt      = 10             ute      = -1.6           kt1      = -0.28
+kt1l     = 8e-09          lii      = 0              kt2      = -0.0646
+ua1      = 3.37e-10       ub1      = -3.12e-18      uc1      = -6.1e-10
+at       = 65000          tcjswg   = 0.0005         wl       = 0
+wln      = 1              ww       = 0              wwn      = 3
+wwl      = 0              ll       = 0              lln      = 2
+lw       = 0              lwn      = 3              lwl      = 0
+capmod   = 2              xpart    = 0              cjswg    = 1e-09
+pbswg    = 1              mjswg    = 0.5            csdesw   = 0
+csdmin   = 1.6e-05        cgdo     = 5.5e-10        cgso     = 1e-10
+cgeo     = 0              cgsl     = 0              cgdl     = 0
+ckappa   = 3              cf       = 0              clc      = 1e-06
+cle      = 0.6            binunit  = 1              shmod    = 1
+rbody    = 20             rbsh     = 10             cth0     = 1e-05
+ndiode   = 1.07           ntun     = 10             vtun0    = 0
+isbjt    = 1e-06          nbjt     = 1              lbjt0    = 2e-07
+vabjt    = 0              aely     = 0              ahli     = 0
+isdif    = 1e-07          isrec    = 0.005          istun    = 1e-08
+xbjt     = 1e-20          xdif     = 1.6            xrec     = 0.8
+xtun     = 6              ntrecf   = 0.1            ntrecr   = -1
+tt       = 3e-10          ln       = 6e-07          nrecf0   = 2.4
+nrecr0   = 10             vrec0    = 0              vsdth    = 1.1
+vsdfb    = 0.4            asd      = 0.3            dlcb     = 0
+dlbg     = 0              delvt    = 0              fbody    = 1
+acde     = 0              moin     = 15             ldif0    = 0.001
+ndif     = -1             soimod   = 2              vbsa     = 0
+dvbd1    = 0.4            dvbd0    = 0              nofffd   = 1
+vofffd   = 0              moinfd   = 10000          dk2b     = 0.4
+k2b      = 0              wth0     = 4e-06          rhalo    = 1e+20
+nrb      = 1              k1b      = 0              rgatemod = 1
+rshg     = 1.6            xrcrg1   = 12             xrcrg2   = 1
+ngcon    = 1              xgw      = 0              xgl      = 0
+wpclm    = 0              lpclm    = 0
