subckt psoi2 (d g s b)

parameters l=90n w=200n nf=1

M0 (d g s b) ps_psoi2 l=l w=nf*w nf=nf

ends
