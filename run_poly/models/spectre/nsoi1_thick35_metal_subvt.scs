model nsoi1_thick35_metal_subvt bsimsoi type=n
+level    = 70             version  = 4.4            capmod   = 2
+mobmod   = 1              tox      = 3.5e-09        cdsc     = 0.003
+cdscb    = 0              cdscd    = 0              cit      = 0
+nfactor  = 1              vsat     = 80000          at       = 0
+a0       = 1              ags      = 0              a1       = 0
+a2       = 1              keta     = 0              nsub     = 2e+14
+nch      = 1e+15          ngate    = 1e+20          k1       = 0.01
+kt1      = 0              kt1l     = 0              kt2      = 0
+k2       = 0.121          k3       = -10            k3b      = 0
+w0       = 2e-07          lpe0     = 0              lpeb     = 0
+dvt0     = 0.34           dvt1     = 0.7            dvt2     = 0
+dvt0w    = 0              dvt1w    = 100000         dvt2w    = 0
+vth0     = 0.54           ua       = 0              ua1      = 0
+ub       = 0              ub1      = 0              uc       = 0
+uc1      = 0              u0       = 285            ute      = 0
+voff     = -0.18          minv     = 0              tnom     = 22
+xpart    = 0              delta    = 0.03           rdsw     = 1040
+prwg     = 0              prwb     = 0              prt      = 0
+dsub     = 1.62           eta0     = 0.2            etab     = 0
+pclm     = 1              drout    = 0.04           pdiblc1  = 0
+pdiblc2  = 0              pdiblcb  = 0              pvag     = 0
+shmod    = 0              tbox     = 1.4e-07        tsi      = 2.5e-08
+agidl    = 0              bgidl    = 0              ndiode   = 1.05
+ndioded  = 1.09           xbjt     = 0              xdif     = 0
+xrec     = 0              xtun     = 0              lint     = -1.33e-08
+ll       = 0              lln      = 0              lw       = 0
+lwn      = 0              lwl      = 0              wr       = 1
+wint     = 0              dwg      = 0              dwb      = 0
+wl       = 0              wln      = 0              ww       = 0
+wwn      = 0              wwl      = 0              b0       = 0
+b1       = 0              alpha0   = 5e-09          dvtp0    = 0
+dvtp1    = 0              dvtp2    = 0              dvtp3    = 0
+dvtp4    = 0              k1w1     = 0              k1w2     = 0
+ketas    = 0              dwbc     = 0              beta0    = 0
+beta1    = 0              beta2    = 0.08           vdsatii0 = 0.9
+tii      = 0              lii      = 0              sii0     = 1
+sii1     = 0              sii2     = 0              siid     = 0
+fbjtii   = 0              esatii   = 1e+08          ntun     = 0
+nrecf0   = 2              nrecr0   = 10             isbjt    = 1e-06
+idbjt    = 4.5e-06        isdif    = 1e-07          iddif    = 1e-07
+isrec    = 1e-05          idrec    = 1e-05          istun    = 0
+idtun    = 0              ln       = 2e-06          vrec0    = 0
+vtun0    = 0              nbjt     = 1              lbjt0    = 2e-07
+ldif0    = 0              vabjt    = 10             aely     = 0
+ahli     = 0              rbody    = 0              rbsh     = 0
+ndif     = 0              asd      = 0              csdesw   = 0
+ntrecf   = 0              ntrecr   = 0              dlcb     = 0
+fbody    = 1              acde     = 0              moin     = 15
+delvt    = 0              kb1      = 0              dlbg     = 0
+vbsa     = 0              nofffd   = 1              vofffd   = 0.3
+k1b      = 0              k2b      = 0              dk2b     = 0.5
+dvbd0    = 0              dvbd1    = 0.28           moinfd   = 100000
+fdmod    = 0              cdsbs    = 0              ngidl    = 0
+rth0     = 0              soimod   = 2
